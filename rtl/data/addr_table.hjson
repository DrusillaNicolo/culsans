// Copyright EPFL contributors.
// Licensed under the Apache License, Version 2.0, see LICENSE for details.
// SPDX-License-Identifier: Apache-2.0

{ name: "addr_table",
  clock_primary: "clk_i",
  reset_primary: "rst_ni",
  
  bus_interfaces: [
    {
      protocol: "reg_iface",
      direction: "device",
    },
  ],
  regwidth: "32",
  registers: [
    {
      multireg: {
        name: "START_ADDR",
        desc: "Start address of the entry",
        count: "4",
        cname: "start_addr",
        swaccess: "rw",
        hwaccess: "hro",
        fields: [
          { bits: "31:0" }
        ]
      }
    },
        {
      multireg: {
        name: "END_ADDR",
        desc: "End address of the entry",
        count: "4",
        cname: "end_addr",
        swaccess: "rw",
        hwaccess: "hro",
        fields: [
          { bits: "31:0" }
        ]
      }
    },
    {
      multireg: {
        name: "VALID",
        desc: "Valid bit for entry N",
        count: "4",
        cname: "valid",
        swaccess: "rw",
        hwaccess: "hro",
        fields: [
          { bits: "31:0",
            name: "valid",
            desc: "Set by SW if the entry is valid"
          }
        ]
      }
    },
        {
      multireg: {
        name: "DIRTY",
        desc: "Dirty bit for entry N",
        count: "4",
        cname: "dirty",
        swaccess: "rw",
        hwaccess: "hro",
        fields: [
          { bits: "31:0",
            name: "dirty",
            desc: "Set by SW if the entry is dirty"
          }
        ]
      }
    },
            {
      multireg: {
        name: "SHARED",
        desc: "Shared bit for entry N",
        count: "4",
        cname: "shared",
        swaccess: "rw",
        hwaccess: "hrw",
        fields: [
          { bits: "31:0",
            name: "shared",
            desc: "Set by SW if the entry is shared"
          }
        ]
      }
    },
    {
      name: "START",
      desc: "When core0 finishes to fill the add table, we set this reg and we start with the invalidation process",
      swaccess: "rw",
      hwaccess: "hrw",
      fields: [
        { bits: "0",
          name: "start",
          desc: "Start signal for the invalidation process"
        }
      ]
    },
    {
      name: "END_FLAG",
      desc: "Flag indicating the end of the invalidation process",
      swaccess: "rw",
      hwaccess: "hrw",
      fields: [
        { bits: "0",
          name: "end_flag",
          desc: "Flag indicating the end of the invalidation process"
        }
      ]
    }
  ]
}