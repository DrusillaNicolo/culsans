// Copyright EPFL contributors.
// Licensed under the Apache License, Version 2.0, see LICENSE for details.
// SPDX-License-Identifier: Apache-2.0

{ name: "addr_table",
  clock_primary: "clk_i",
  reset_primary: "rst_ni",
  
  bus_interfaces: [
    {
      protocol: "reg_iface",
      direction: "device",
    },
  ],
  regwidth: "64",
  registers: [
    {
      multireg: {
        name: "DATA",
        desc: "Entry register",
        count: "25",
        cname: "data",
        swaccess: "rw",
        hwaccess: "hro",
        fields: [
          { bits: "63:0" }
        ]
      }
    },
    {
      multireg: {
        name: "VALID",
        desc: "Valid bit for entry N",
        count: "25",
        cname: "valid",
        swaccess: "rw",
        hwaccess: "hro",
        fields: [
          { bits: "0",
            name: "valid",
            desc: "Set by SW if the entry is valid"
          }
        ]
      }
    }
  ]
}